* Buck Converter - Test Circuit
Vin in 0 DC 48
Vpwm gate 0 PULSE(0 5 0 10n 10n 4.545u 9.091u)
S1 in sw gate 0 SW1
.model SW1 SW(Ron=0.01 Roff=1Meg Vt=2.5 Vh=0.1)
L1 sw out 500u
D1 0 sw DMOD
.model DMOD D(Is=1e-14 Rs=0.01)
C1 out 0 100u IC=12
R1 out 0 6
.tran 50n 500u 400u
.end
